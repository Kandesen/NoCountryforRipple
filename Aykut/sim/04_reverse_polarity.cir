* EE463 60 W sync buck - Step 4: input reverse-polarity protection (optional add-on)
* Low-side N-MOSFET (BSC040N08NS5): drain -> VIN- terminal, source -> circuit ground,
* gate -> VIN+ through 100 k, 12 V Zener gate clamp (BZT52C12). Bypass footprint JP_RP (0 ohm) not fitted.
* The converter is represented by its input capacitors and an equivalent 60 W load at 48 V (37 ohm).
* VIN = +48 V (normal) or -48 V (reversed); set in the .control block.
.param VIN=48

Vin   vpos_s vneg_t {VIN}
Rsrc  vpos_s vpos 30m
* reverse-polarity MOSFET and gate drive
Mrp   vneg_t g 0 BSC040
Rg    vpos g 100k
Dz    0 g DZ12
* converter input: 4 x 2.2 uF ceramic, 100 uF electrolytic, equivalent load
Ccin  vpos 0 4u
Celin vpos nel 100u
Rel   nel 0 0.2
Rconv vpos 0 37

.model DZ12 D(Is=1e-12 N=1 BV=12 IBV=5m Rs=5)
.model BSC040 VDMOS(Rg=1.2 Rd=4.5m Rs=0.3m Vto=3.0 Kp=150 Lambda=0.01
+ Cgdmax=1n Cgdmin=30p a=0.5 Cgs=3n Cjo=3.5n Vj=0.7 M=0.5 Is=1e-12 N=1.05 Rb=2m TT=10n BV=80)

.tran 1u 3m
.end
